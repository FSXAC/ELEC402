// Design: ELEC402/BUFFER
simulator lang=spectre
global 0
parameters CL=1p vdd=1 vin=1
include "/ubc/ece/data/cmc2/kits/AMSKIT616_GPDK/tech/gpdk045_v_4_0/gpdk045/../models/spectre/gpdk045.scs" section=tt

// ELEC402/BUFFER/schematic
NM0 (VDD INPUT OUTPUT 0) g45n1svt w=(120n) l=45n nf=1 m=(1)
PM0 (0 INPUT OUTPUT VDD) g45p1svt w=(240n) l=45n nf=1 m=(1)
V2 (INPUT 0) vsource dc=vin type=dc
V0 (VDD 0) vsource dc=vdd type=dc
C0 (OUTPUT 0) capacitor c=CL
simulatorOptions options temp=27
dc dc hysteresis=yes param=vin start=0 stop=vdd
