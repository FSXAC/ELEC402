simulator( 'spectre )
design(	 "/ubc/ece/home/ugrads/p/p5h0b/elec402/ELEC402_projects/proj3/cds/simulation/BUFFER/spectre/schematic/netlist/netlist")
resultsDir( "/ubc/ece/home/ugrads/p/p5h0b/elec402/ELEC402_projects/proj3/cds/simulation/BUFFER/spectre/schematic" )
modelFile(
    '("/ubc/ece/data/cmc2/kits/AMSKIT616_GPDK/tech/gpdk045_v_4_0/gpdk045/../models/spectre/gpdk045.scs" "tt")
)
analysis('dc ?param "vin"  ?start "0"  ?stop "1"  )
desVar(	  "vin" 1	)
desVar(	  "vdd" 1	)
desVar(	  "CL" 1p	)
envOption(
	'analysisOrder  list("dc")
)
temp( 27 )
run()
selectResult( 'dc )
plot(getData("/OUTPUT") getData("/INPUT") )
modelFile(
    '("/ubc/ece/data/cmc2/kits/AMSKIT616_GPDK/tech/gpdk045_v_4_0/gpdk045/../models/spectre/gpdk045.scs" "tt")
)
analysis('dc ?start "1"  ?stop "0"  )
run()
selectResult( 'dc )
plot(getData("/INPUT") getData("/OUTPUT") )
modelFile(
    '("/ubc/ece/data/cmc2/kits/AMSKIT616_GPDK/tech/gpdk045_v_4_0/gpdk045/../models/spectre/gpdk045.scs" "tt")
)
analysis('dc ?hysteresis t  ?start "0"  ?stop "1"  )
run()
selectResult( 'dc )
plot(getData("/INPUT") getData("/OUTPUT") )
modelFile(
    '("/ubc/ece/data/cmc2/kits/AMSKIT616_GPDK/tech/gpdk045_v_4_0/gpdk045/../models/spectre/gpdk045.scs" "tt")
)
run()
selectResult( 'dc )
plot(getData("/INPUT") getData("/OUTPUT") )
modelFile(
    '("/ubc/ece/data/cmc2/kits/AMSKIT616_GPDK/tech/gpdk045_v_4_0/gpdk045/../models/spectre/gpdk045.scs" "tt")
)
run()
selectResult( 'dc )
plot(getData("/INPUT") getData("/OUTPUT") )
modelFile(
    '("/ubc/ece/data/cmc2/kits/AMSKIT616_GPDK/tech/gpdk045_v_4_0/gpdk045/../models/spectre/gpdk045.scs" "tt")
)
run()
selectResult( 'dc )
plot(getData("/INPUT") getData("/OUTPUT") )
modelFile(
    '("/ubc/ece/data/cmc2/kits/AMSKIT616_GPDK/tech/gpdk045_v_4_0/gpdk045/../models/spectre/gpdk045.scs" "tt")
)
analysis('dc ?stop "3"  )
desVar(	  "vdd" 3	)
run()
selectResult( 'dc )
plot(getData("/INPUT") getData("/OUTPUT") )
modelFile(
    '("/ubc/ece/data/cmc2/kits/AMSKIT616_GPDK/tech/gpdk045_v_4_0/gpdk045/../models/spectre/gpdk045.scs" "tt")
)
analysis('dc ?stop "vdd"  )
desVar(	  "vdd" 1.2	)
desVar(	  "CL" 1f	)
run()
selectResult( 'dc )
plot(getData("/INPUT") getData("/OUTPUT") )
modelFile(
    '("/ubc/ece/data/cmc2/kits/AMSKIT616_GPDK/tech/gpdk045_v_4_0/gpdk045/../models/spectre/gpdk045.scs" "tt")
)
run()
selectResult( 'dc )
plot(getData("/INPUT") getData("/OUTPUT") )
modelFile(
    '("/ubc/ece/data/cmc2/kits/AMSKIT616_GPDK/tech/gpdk045_v_4_0/gpdk045/../models/spectre/gpdk045.scs" "tt")
)
run()
selectResult( 'dc )
plot(getData("/INPUT") getData("/OUTPUT") )
modelFile(
    '("/ubc/ece/data/cmc2/kits/AMSKIT616_GPDK/tech/gpdk045_v_4_0/gpdk045/../models/spectre/gpdk045.scs" "tt")
)
run()
selectResult( 'dc )
plot(getData("/INPUT") getData("/OUTPUT") )
modelFile(
    '("/ubc/ece/data/cmc2/kits/AMSKIT616_GPDK/tech/gpdk045_v_4_0/gpdk045/../models/spectre/gpdk045.scs" "tt")
)
run()
selectResult( 'dc )
plot(getData("/INPUT") getData("/OUTPUT") )
modelFile(
    '("/ubc/ece/data/cmc2/kits/AMSKIT616_GPDK/tech/gpdk045_v_4_0/gpdk045/../models/spectre/gpdk045.scs" "tt")
)
desVar(	  "vdd" 1	)
run()
selectResult( 'dc )
plot(getData("/INPUT") getData("/OUTPUT") )
modelFile(
    '("/ubc/ece/data/cmc2/kits/AMSKIT616_GPDK/tech/gpdk045_v_4_0/gpdk045/../models/spectre/gpdk045.scs" "tt")
)
desVar(	  "CL" 1p	)
run()
selectResult( 'dc )
plot(getData("/INPUT") getData("/OUTPUT") )
modelFile(
    '("/ubc/ece/data/cmc2/kits/AMSKIT616_GPDK/tech/gpdk045_v_4_0/gpdk045/../models/spectre/gpdk045.scs" "tt")
)
analysis('dc ?saveOppoint t  )
run()
selectResult( 'dc )
plot(getData("/INPUT") getData("/OUTPUT") )
